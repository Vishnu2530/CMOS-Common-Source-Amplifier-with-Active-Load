* Common Source Amplifier with Resistive Load
* NMOS: kp=200u, VTO=0.4 (long-channel square-law model, no parasitic caps)
* VDD = 1.8V, RD = 10k, W = 18u, L = 0.18u  ->  W/L = 100

.model nmos NMOS(kp=200u, VTO=0.4)

* --- Supplies ---
VDD   vdd   0   DC 1.8

* --- Bias / input ---
* Part A (transient): SINE(offset amplitude freq) -> 0.5V DC bias, 1mV amplitude, 1kHz
V2    n003  0   SINE(0.5 1m 1k)
* Part B (AC): swap V2 for an AC source with 1V AC amplitude for direct dB gain readout
* V2  n003  0   AC 1

* --- Coupling capacitor (blocks DC bias, passes AC signal) ---
C1    n003  gate  10u

* --- Drain resistor ---
RD    vdd   vout  10k

* --- NMOS: drain=vout, gate=gate, source=0, bulk=0 ---
M1    vout  gate  0  0  nmos  W=18u  L=0.18u

* =========================================================
* Part A — Transient Analysis
* Output: V(vout) vs V(n003); expect |Av| = gm*RD = 20, 180 deg phase shift
.tran 0 100m 90m 1m

* =========================================================
* Part B — AC Analysis (Bode plot)
* Uncomment for AC sweep; comment out the .tran line above
* .ac dec 1000 1 1G

* --- (ii) W parametric sweep (RD = 10k fixed) ---
* .step param W 1u 100u 20u
* M1  vout  gate  0  0  nmos  W={W}  L=0.18u

* --- (iii) RD parametric sweep (W = 18u fixed) ---
* .step param R_var 1k 100k 10k
* RD  vdd  vout  {R_var}

.backanno
.end
